* SKY130 flat model -- CMOS inverter DC transfer characteristic
* PMOS sized 2x NMOS for roughly symmetric switching
.include ../sky130_ptm_style.lib
.option scale=1u

Vdd vdd 0 1.8
Vin in  0 0

M1 out in 0   0   sky130_nmos_130 L=0.15 W=1
M2 out in vdd vdd sky130_pmos_130 L=0.15 W=2

.dc Vin 0 1.8 0.01

* --- LTspice: after Run, add trace V(out) ---
*.control
*run
*plot v(out)
*.endc
.end
